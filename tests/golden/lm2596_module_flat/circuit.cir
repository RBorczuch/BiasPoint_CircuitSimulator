* LM2596 step-down module, flattened by hand (no subcircuits, parameters substituted)
* The same circuit as examples/lm2596_module.bpt: project -> module -> IC.
.func soft(x) {0.5+0.5*tanh(x)}
.func sat(x, m) {x/pwr(1+pwr(x*x/(m*m),4),0.125)}
* IC (fsw = 150k, vref = 1.23, ron = 0.39, ilim = 3.6, iq = 5m, tss = 1m)
Rfb fb 0 10meg
Bq in 0 I=5m
Bsw in sw I=sat(V(in,sw)*V(drv)/0.39,3.6)
Bon on 0 V=soft(10*(V(in)-4.5))*soft(20*(1.3-V(0)))
Bss 0 css I=10u*V(on)
Css css 0 8.13008n
Bref css 0 I=max(V(css)-1.23,0)
Bea 0 comp I=20u*(V(css)-V(fb))
Ro comp 0 100meg
Cc comp 0 22n
Bclamp comp 0 I=1m*(V(comp)-min(max(V(comp),0),1.1))
Vramp ramp 0 DC 0 PULSE(0 1 0 6.46667u 0.133333u 0.0666667u 6.66667u)
Bpwm drv 0 V=V(on)*soft(200*(V(comp)-V(ramp)))
* Module (vout = 5): divider 1k * (5 / 1.23 - 1) = 3.06504k
* 470uF 35V electrolytic: C || R leak, then ESR and ESL in series
C1 in c1a 470u
RC1L in c1a 100k
RC1 c1a c1b 80m
LC1 c1b 0 15n
* SS34 Schottky
D1 0 sw SS34
* 33uH power inductor with its winding resistance
L1 sw l1e 33u
RL1 l1e out 50m
R1 out fb 3.06504k
R2 fb 0 1k
* 220uF 35V electrolytic
C2 out c2a 220u
RC2L out c2a 100k
RC2 c2a c2b 100m
LC2 c2b 0 15n
.model SS34 D(IS=5u N=1.1 RS=40m BV=40 IBV=1m CJO=300p VJ=0.4 M=0.5 TT=0)
* Project: 12 V switched on at t = 0, 5 ohm load (1 A)
V1 in 0 DC 0 PWL(0 0 0.2m 12)
RL out 0 5
.end
