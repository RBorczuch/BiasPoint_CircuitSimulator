Series RLC band-pass, output across R
V1 in 0 DC 0 AC 1
L1 in a 1m
C1 a out 1u
R1 out 0 10
.end
