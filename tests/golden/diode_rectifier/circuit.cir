Half-wave rectifier
V1 in 0 SIN(0 5 50)
D1 in out D
R1 out 0 1k
.model D d(is=1e-14 n=1 rs=0.1)
.end
